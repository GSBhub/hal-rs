// Small SoC for hal-rs RDL front-end tests: a UART and a clock controller.
addrmap demo_uart {
    halrs_irq = 37;
    reg {
        field { sw = r; hw = w; } TXE[7:7] = 1;
        field { sw = r; hw = w; onread = rclr; } RXNE[5:5] = 0;
        field { sw = rw; hw = r; onwrite = woclr; } ORE[3:3] = 0;
        field { sw = r; hw = w; } BSY[9:9] = 0;
    } SR @ 0x0;
    reg {
        field { sw = rw; hw = r; } DATA[8:0] = 0;
    } DR @ 0x4;
    reg {
        field { sw = w; hw = r; } KEY[15:0] = 0;
    } KEYR @ 0x8;
};

addrmap demo_clk {
    reg {
        field { sw = rw; hw = r; } PLLON[24:24] = 0;
        field { sw = r; hw = w; } PLLRDY[25:25] = 0;
    } CR @ 0x0;
};

addrmap demo_soc {
    demo_uart uart0 @ 0x40011000;
    demo_clk  clk   @ 0x40023800;
};
